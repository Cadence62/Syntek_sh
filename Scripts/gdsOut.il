streamOutKeys = list(nil
'layerTable                ""
'convertPin                "geometry"
'libVersion                "5.0"
'units                     "micron"
'scale                     0.001
'cellMapTable              ""
'caseSensitivity           "preserve"
'errFile                   "PIPO.LOG.PDB1A"
'outFile                   "/root/simulation/PDB1A.calibre.db"
'viewName                  "layout"
'primaryCell               "PDB1A"
'libName                   "tpa018nv_270a_mt"
'runDir                    "/root/simulation"
)
